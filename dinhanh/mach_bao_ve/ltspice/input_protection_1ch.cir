One-channel protection - exported from the actual ASC geometry
VIN IN 0 PWL FILE="input_sequence.pwl"
R6 IN CLAMP 2k
R8 CLAMP A 330
R9 A 0 47k
R10 N007 OUT 33
XD3 0 Z CLAMP BAV99_PAIR
D4 0 Z D_BZX85C3V3_REP
XU2 A N007 VCC 0 LVC1G17_REP
C2 VCC 0 100n
VCCSRC VCC 0 {VSUP}
CLOAD OUT 0 10p
.include simulation_commands.inc
.tran {TMAX} {TSTOP} 0 {TMAX}
.save V(IN) V(CLAMP) V(A) V(OUT) I(VIN)
.end
