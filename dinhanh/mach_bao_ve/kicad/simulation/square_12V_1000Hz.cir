Exploratory protection model - square_12V_1000Hz
* Standalone one-channel equivalent of the supplied KiCad schematic.
* +3V3 supply is intentionally absent from the passive clamp network.
Vdut in 0 PULSE(0 12 0.001 5e-09 5e-09 0.000499995 0.001)
R1 in mid 1000
R2 mid clamp 1000
Dhi clamp z DBAV
Dlo 0 clamp DBAV
Dz 0 z DZENER
R3 clamp a 330
R4 a 0 47000
Ca a 0 6p
Cstray clamp 0 2e-12

.model DBAV D(Is=2.52n N=1.75 Rs=.568 Cjo=1.5p Tt=4n Bv=100 Ibv=.5u)
.model DZENER D(Is=1n N=1.5 Rs=2 Cjo=500p Bv=3.3 Ibv=.08)

.control
set wr_singlescale
set wr_vecnames
tran 1.6666666666666667e-06 0.012 0 1.6666666666666667e-06
wrdata /media/abuntu/NVME_UBUNTU/Working/20261/Logic_Analyzer_20261/dinhanh/mach_bao_ve/kicad/simulation/square_12V_1000Hz.dat v(in) v(clamp) v(a) v(z) i(Vdut) v(mid)
quit
.endc
.end
